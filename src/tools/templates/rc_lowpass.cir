* First-order RC low-pass
V1 in 0 DC 0 AC 1
R1 in out $R
C1 out 0 $C
.control
set wr_singlescale
set wr_vecnames
ac dec $AC_PPD $AC_FSTART $AC_FSTOP
wrdata ac.txt db(v(out))
quit
.endc
.end
