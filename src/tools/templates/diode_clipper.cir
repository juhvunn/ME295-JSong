* Diode clipper: series R into antiparallel 1N4148 to ground
V1 in 0 DC 0 AC 1 SIN(0 $VIN_AMP $FREQ)
R1 in out $R1
D1 out 0 D1N4148
D2 0 out D1N4148
C1 out 0 $C1
.model D1N4148 D(Is=2.52n Rs=0.568 N=1.752 Cjo=4p M=0.4 tt=20n)
.control
set wr_singlescale
set wr_vecnames
ac dec $AC_PPD $AC_FSTART $AC_FSTOP
wrdata ac.txt db(v(out))
tran $TSTEP $TSTOP
wrdata tran.txt v(in) v(out)
quit
.endc
.end
